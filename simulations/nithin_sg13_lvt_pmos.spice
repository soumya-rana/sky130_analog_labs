** sch_path: /home/ubuntu/rough_work/nithin_sg13_lvt_pmos.sch
**.subckt nithin_sg13_lvt_pmos
V1 net2 GND 0.825
VGS net2 net1 0.825
VD1 net2 net3 0
.save i(vd1)
VD2 net2 net12 0
.save i(vd2)
VD3 net2 net4 0
.save i(vd3)
VD4 net2 net5 0
.save i(vd4)
VD5 net2 net6 0
.save i(vd5)
VD6 net2 net7 0
.save i(vd6)
VD7 net2 net13 0
.save i(vd7)
VD8 net2 net8 0
.save i(vd8)
VD9 net2 net9 0
.save i(vd9)
VD10 net2 net14 0
.save i(vd10)
VD11 net2 net10 0
.save i(vd11)
XM1 GND net1 net3 net3 sg13_lv_pmos w=2u l=0.13u ng=1 m=1
XM2 GND net1 net12 net12 sg13_lv_pmos w=2u l=0.25u ng=1 m=1
XM3 GND net1 net4 net4 sg13_lv_pmos w=2u l=0.5u ng=1 m=1
XM4 GND net1 net5 net5 sg13_lv_pmos w=2u l=0.75u ng=1 m=1
XM5 GND net1 net6 net6 sg13_lv_pmos w=2u l=1u ng=1 m=1
XM6 GND net1 net7 net7 sg13_lv_pmos w=2u l=1.25u ng=1 m=1
XM7 GND net1 net13 net13 sg13_lv_pmos w=2u l=1.5u ng=1 m=1
XM8 GND net1 net8 net8 sg13_lv_pmos w=2u l=1.75u ng=1 m=1
XM9 GND net1 net9 net9 sg13_lv_pmos w=2u l=2u ng=1 m=1
XM10 GND net1 net14 net14 sg13_lv_pmos w=2u l=2.25u ng=1 m=1
XM11 GND net1 net10 net10 sg13_lv_pmos w=2u l=2.5u ng=1 m=1
XM12 GND net1 net11 net11 sg13_lv_pmos w=2u l=2.75u ng=1 m=1
VD12 net2 net11 0
.save i(vd12)
XM13 GND net1 net15 net15 sg13_lv_pmos w=2u l=3u ng=1 m=1
VD13 net2 net15 0
.save i(vd13)
**** begin user architecture code

.save @n.xm1.nsg13_lv_pmos[gm]
.save @n.xm1.nsg13_lv_pmos[id]
.save @n.xm1.nsg13_lv_pmos[vth]
.save @n.xm1.nsg13_lv_pmos[gds]
.save @n.xm1.nsg13_lv_pmos[cgg]
.save @n.xm1.nsg13_lv_pmos[cgs]
.save @n.xm1.nsg13_lv_pmos[cgd]
.save @n.xm2.nsg13_lv_pmos[gm]
.save @n.xm2.nsg13_lv_pmos[id]
.save @n.xm2.nsg13_lv_pmos[vth]
.save @n.xm2.nsg13_lv_pmos[gds]
.save @n.xm2.nsg13_lv_pmos[cgg]
.save @n.xm2.nsg13_lv_pmos[cgs]
.save @n.xm2.nsg13_lv_pmos[cgd]
.save @n.xm3.nsg13_lv_pmos[gm]
.save @n.xm3.nsg13_lv_pmos[id]
.save @n.xm3.nsg13_lv_pmos[vth]
.save @n.xm3.nsg13_lv_pmos[gds]
.save @n.xm3.nsg13_lv_pmos[cgg]
.save @n.xm3.nsg13_lv_pmos[cgs]
.save @n.xm3.nsg13_lv_pmos[cgd]
.save @n.xm4.nsg13_lv_pmos[gm]
.save @n.xm4.nsg13_lv_pmos[id]
.save @n.xm4.nsg13_lv_pmos[vth]
.save @n.xm4.nsg13_lv_pmos[gds]
.save @n.xm4.nsg13_lv_pmos[cgg]
.save @n.xm4.nsg13_lv_pmos[cgs]
.save @n.xm4.nsg13_lv_pmos[cgd]
.save @n.xm5.nsg13_lv_pmos[gm]
.save @n.xm5.nsg13_lv_pmos[id]
.save @n.xm5.nsg13_lv_pmos[vth]
.save @n.xm5.nsg13_lv_pmos[gds]
.save @n.xm5.nsg13_lv_pmos[cgg]
.save @n.xm5.nsg13_lv_pmos[cgs]
.save @n.xm5.nsg13_lv_pmos[cgd]
.save @n.xm6.nsg13_lv_pmos[gm]
.save @n.xm6.nsg13_lv_pmos[id]
.save @n.xm6.nsg13_lv_pmos[vth]
.save @n.xm6.nsg13_lv_pmos[gds]
.save @n.xm6.nsg13_lv_pmos[cgg]
.save @n.xm6.nsg13_lv_pmos[cgs]
.save @n.xm6.nsg13_lv_pmos[cgd]
.save @n.xm7.nsg13_lv_pmos[gm]
.save @n.xm7.nsg13_lv_pmos[id]
.save @n.xm7.nsg13_lv_pmos[vth]
.save @n.xm7.nsg13_lv_pmos[gds]
.save @n.xm7.nsg13_lv_pmos[cgg]
.save @n.xm7.nsg13_lv_pmos[cgs]
.save @n.xm7.nsg13_lv_pmos[cgd]
.save @n.xm7.nsg13_lv_pmos[gm]
.save @n.xm7.nsg13_lv_pmos[id]
.save @n.xm7.nsg13_lv_pmos[vth]
.save @n.xm7.nsg13_lv_pmos[gds]
.save @n.xm7.nsg13_lv_pmos[cgg]
.save @n.xm7.nsg13_lv_pmos[cgs]
.save @n.xm7.nsg13_lv_pmos[cgd]
.save @n.xm8.nsg13_lv_pmos[gm]
.save @n.xm8.nsg13_lv_pmos[id]
.save @n.xm8.nsg13_lv_pmos[vth]
.save @n.xm8.nsg13_lv_pmos[gds]
.save @n.xm8.nsg13_lv_pmos[cgg]
.save @n.xm8.nsg13_lv_pmos[cgs]
.save @n.xm8.nsg13_lv_pmos[cgd]
.save @n.xm9.nsg13_lv_pmos[gm]
.save @n.xm9.nsg13_lv_pmos[id]
.save @n.xm9.nsg13_lv_pmos[vth]
.save @n.xm9.nsg13_lv_pmos[gds]
.save @n.xm9.nsg13_lv_pmos[cgg]
.save @n.xm9.nsg13_lv_pmos[cgs]
.save @n.xm9.nsg13_lv_pmos[cgd]
.save @n.xm10.nsg13_lv_pmos[gm]
.save @n.xm10.nsg13_lv_pmos[id]
.save @n.xm10.nsg13_lv_pmos[vth]
.save @n.xm10.nsg13_lv_pmos[gds]
.save @n.xm10.nsg13_lv_pmos[cgg]
.save @n.xm10.nsg13_lv_pmos[cgs]
.save @n.xm10.nsg13_lv_pmos[cgd]
.save @n.xm11.nsg13_lv_pmos[gm]
.save @n.xm11.nsg13_lv_pmos[id]
.save @n.xm11.nsg13_lv_pmos[vth]
.save @n.xm11.nsg13_lv_pmos[gds]
.save @n.xm11.nsg13_lv_pmos[cgg]
.save @n.xm11.nsg13_lv_pmos[cgs]
.save @n.xm11.nsg13_lv_pmos[cgd]
.save @n.xm12.nsg13_lv_pmos[gm]
.save @n.xm12.nsg13_lv_pmos[id]
.save @n.xm12.nsg13_lv_pmos[vth]
.save @n.xm12.nsg13_lv_pmos[gds]
.save @n.xm12.nsg13_lv_pmos[cgg]
.save @n.xm12.nsg13_lv_pmos[cgs]
.save @n.xm12.nsg13_lv_pmos[cgd]
.save @n.xm13.nsg13_lv_pmos[gm]
.save @n.xm13.nsg13_lv_pmos[id]
.save @n.xm13.nsg13_lv_pmos[vth]
.save @n.xm13.nsg13_lv_pmos[gds]
.save @n.xm13.nsg13_lv_pmos[cgg]
.save @n.xm13.nsg13_lv_pmos[cgs]
.save @n.xm13.nsg13_lv_pmos[cgd]

.option wnflag=1
.option savecurrents
.temp 27
.control
save all
dc VGS 0 1.65 5m
remzerovec
write /headless/.xschem/simulations/gmid_pmos_sg13_lv_pmos_tb.raw

plot @n.xm1.nsg13_lv_pmos[gm]
plot @n.xm2.nsg13_lv_pmos[gm]
plot @n.xm3.nsg13_lv_pmos[gm]
plot @n.xm4.nsg13_lv_pmos[gm]
plot @n.xm5.nsg13_lv_pmos[gm]
plot @n.xm6.nsg13_lv_pmos[gm]
plot @n.xm7.nsg13_lv_pmos[gm]
plot @n.xm8.nsg13_lv_pmos[gm]
plot @n.xm9.nsg13_lv_pmos[gm]
plot @n.xm10.nsg13_lv_pmos[gm]
plot @n.xm11.nsg13_lv_pmos[gm]
plot @n.xm12.nsg13_lv_pmos[gm]
plot @n.xm13.nsg13_lv_pmos[gm]
plot @n.xm1.nsg13_lv_pmos[vth]
plot @n.xm1.nsg13_lv_pmos[ids]
let gm1=@n.xm1.nsg1_lv_pmos[gm]
let id1=@n.xm1.nsg1_lv_pmos[ids]
let gmid1=gm1/id1
plot gmid1

wrdata /headless/.xschem/simulations/gmid_pmos_1_sg13_lv_pmos_tb.txt @n.xm1.nsg13_lv_pmos[gm] @n.xm1.nsg13_lv_pmos[ids] @n.xm1.nsg13_lv_pmos[vth] @n.xm1.nsg13_lv_pmos[gds] @n.xm1.nsg13_lv_pmos[cgg] @n.xm1.nsg13_lv_pmos[cgs] @n.xm1.nsg13_lv_pmos[cgd] @n.xm1.nsg13_lv_pmos[vgs]
wrdata /headless/.xschem/simulations/gmid_pmos_2_sg13_lv_pmos_tb.txt @n.xm2.nsg13_lv_pmos[gm] @n.xm2.nsg13_lv_pmos[ids] @n.xm2.nsg13_lv_pmos[vth] @n.xm2.nsg13_lv_pmos[gds] @n.xm2.nsg13_lv_pmos[cgg] @n.xm2.nsg13_lv_pmos[cgs] @n.xm2.nsg13_lv_pmos[cgd] @n.xm2.nsg13_lv_pmos[vgs]
wrdata /headless/.xschem/simulations/gmid_pmos_3_sg13_lv_pmos_tb.txt @n.xm3.nsg13_lv_pmos[gm] @n.xm3.nsg13_lv_pmos[ids] @n.xm3.nsg13_lv_pmos[vth] @n.xm3.nsg13_lv_pmos[gds] @n.xm3.nsg13_lv_pmos[cgg] @n.xm3.nsg13_lv_pmos[cgs] @n.xm3.nsg13_lv_pmos[cgd] @n.xm3.nsg13_lv_pmos[vgs]
wrdata /headless/.xschem/simulations/gmid_pmos_4_sg13_lv_pmos_tb.txt @n.xm4.nsg13_lv_pmos[gm] @n.xm4.nsg13_lv_pmos[ids] @n.xm4.nsg13_lv_pmos[vth] @n.xm4.nsg13_lv_pmos[gds] @n.xm4.nsg13_lv_pmos[cgg] @n.xm4.nsg13_lv_pmos[cgs] @n.xm4.nsg13_lv_pmos[cgd] @n.xm4.nsg13_lv_pmos[vgs]
wrdata /headless/.xschem/simulations/gmid_pmos_5_sg13_lv_pmos_tb.txt @n.xm5.nsg13_lv_pmos[gm] @n.xm5.nsg13_lv_pmos[ids] @n.xm5.nsg13_lv_pmos[vth] @n.xm5.nsg13_lv_pmos[gds] @n.xm5.nsg13_lv_pmos[cgg] @n.xm5.nsg13_lv_pmos[cgs] @n.xm5.nsg13_lv_pmos[cgd] @n.xm5.nsg13_lv_pmos[vgs]
wrdata /headless/.xschem/simulations/gmid_pmos_6_sg13_lv_pmos_tb.txt @n.xm6.nsg13_lv_pmos[gm] @n.xm6.nsg13_lv_pmos[ids] @n.xm6.nsg13_lv_pmos[vth] @n.xm6.nsg13_lv_pmos[gds] @n.xm6.nsg13_lv_pmos[cgg] @n.xm6.nsg13_lv_pmos[cgs] @n.xm6.nsg13_lv_pmos[cgd] @n.xm6.nsg13_lv_pmos[vgs]
wrdata /headless/.xschem/simulations/gmid_pmos_7_sg13_lv_pmos_tb.txt @n.xm7.nsg13_lv_pmos[gm] @n.xm7.nsg13_lv_pmos[ids] @n.xm7.nsg13_lv_pmos[vth] @n.xm7.nsg13_lv_pmos[gds] @n.xm7.nsg13_lv_pmos[cgg] @n.xm7.nsg13_lv_pmos[cgs] @n.xm7.nsg13_lv_pmos[cgd] @n.xm7.nsg13_lv_pmos[vgs]
wrdata /headless/.xschem/simulations/gmid_pmos_8_sg13_lv_pmos_tb.txt @n.xm8.nsg13_lv_pmos[gm] @n.xm8.nsg13_lv_pmos[ids] @n.xm8.nsg13_lv_pmos[vth] @n.xm8.nsg13_lv_pmos[gds] @n.xm8.nsg13_lv_pmos[cgg] @n.xm8.nsg13_lv_pmos[cgs] @n.xm8.nsg13_lv_pmos[cgd] @n.xm8.nsg13_lv_pmos[vgs]
wrdata /headless/.xschem/simulations/gmid_pmos_9_sg13_lv_pmos_tb.txt @n.xm9.nsg13_lv_pmos[gm] @n.xm9.nsg13_lv_pmos[ids] @n.xm9.nsg13_lv_pmos[vth] @n.xm9.nsg13_lv_pmos[gds] @n.xm9.nsg13_lv_pmos[cgg] @n.xm9.nsg13_lv_pmos[cgs] @n.xm9.nsg13_lv_pmos[cgd] @n.xm9.nsg13_lv_pmos[vgs]
wrdata /headless/.xschem/simulations/gmid_pmos_10_sg13_lv_pmos_tb.txt @n.xm10.nsg13_lv_pmos[gm] @n.xm10.nsg13_lv_pmos[ids] @n.xm10.nsg13_lv_pmos[vth] @n.xm10.nsg13_lv_pmos[gds] @n.xm10.nsg13_lv_pmos[cgg] @n.xm10.nsg13_lv_pmos[cgs] @n.xm10.nsg13_lv_pmos[cgd] @n.xm10.nsg13_lv_pmos[vgs]
wrdata /headless/.xschem/simulations/gmid_pmos_11_sg13_lv_pmos_tb.txt @n.xm11.nsg13_lv_pmos[gm] @n.xm11.nsg13_lv_pmos[ids] @n.xm11.nsg13_lv_pmos[vth] @n.xm11.nsg13_lv_pmos[gds] @n.xm11.nsg13_lv_pmos[cgg] @n.xm11.nsg13_lv_pmos[cgs] @n.xm11.nsg13_lv_pmos[cgd] @n.xm11.nsg13_lv_pmos[vgs]
wrdata /headless/.xschem/simulations/gmid_pmos_12_sg13_lv_pmos_tb.txt @n.xm12.nsg13_lv_pmos[gm] @n.xm12.nsg13_lv_pmos[ids] @n.xm12.nsg13_lv_pmos[vth] @n.xm12.nsg13_lv_pmos[gds] @n.xm12.nsg13_lv_pmos[cgg] @n.xm12.nsg13_lv_pmos[cgs] @n.xm12.nsg13_lv_pmos[cgd] @n.xm12.nsg13_lv_pmos[vgs]
wrdata /headless/.xschem/simulations/gmid_pmos_13_sg13_lv_pmos_tb.txt @n.xm13.nsg13_lv_pmos[gm] @n.xm13.nsg13_lv_pmos[ids] @n.xm13.nsg13_lv_pmos[vth] @n.xm13.nsg13_lv_pmos[gds] @n.xm12.nsg13_lv_pmos[cgg] @n.xm13.nsg13_lv_pmos[cgs] @n.xm13.nsg13_lv_pmos[cgd] @n.xm13.nsg13_lv_pmos[vgs]
op
remzerovec
write /headless/.xschem/simulations/gmid_pmos_sg13_lv_pmos_tb.raw
quit 0
.endc

.lib cornerMOSlv.lib mos_tt

**** end user architecture code
**.ends
.GLOBAL GND
.end
