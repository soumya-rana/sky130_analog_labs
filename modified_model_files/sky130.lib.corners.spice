* Copyright 2020 The SkyWater PDK Authors
*
* Licensed under the Apache License, Version 2.0 (the "License");
* you may not use this file except in compliance with the License.
* You may obtain a copy of the License at
*
*     https://www.apache.org/licenses/LICENSE-2.0
*
* Unless required by applicable law or agreed to in writing, software
* distributed under the License is distributed on an "AS IS" BASIS,
* WITHOUT WARRANTIES OR CONDITIONS OF ANY KIND, either express or implied.
* See the License for the specific language governing permissions and
* limitations under the License.

******* SkyWater sky130 model library *********

* Typical corner (tt)
.lib tt
.param mc_mm_switch=0
.param mc_pr_switch=0
* MOSFET
.include "corners/tt.spice"
* Resistor/Capacitor
.include "r+c/res_typical__cap_typical.spice"
.include "r+c/res_typical__cap_typical__lin.spice"
* Special cells
.include "corners/tt/specialized_cells.spice"
.endl tt

* Slow-Fast corner (sfhh)
.lib sfhh
.param mc_mm_switch=0
.param mc_pr_switch=0
* MOSFET
.include "corners/sf.spice"
* Resistor/Capacitor
.include "r+c/res_high__cap_high.spice"
.include "r+c/res_high__cap_high__lin.spice"
* Special cells
.include "corners/sf/specialized_cells.spice"
.endl sfhh

* Slow-Fast corner (sfhl)
.lib sfhl
.param mc_mm_switch=0
.param mc_pr_switch=0
* MOSFET
.include "corners/sf.spice"
* Resistor/Capacitor
.include "r+c/res_high__cap_low.spice"
.include "r+c/res_high__cap_low__lin.spice"
* Special cells
.include "corners/sf/specialized_cells.spice"
.endl sfhl

* Slow-Fast corner (sflh)
.lib sflh
.param mc_mm_switch=0
.param mc_pr_switch=0
* MOSFET
.include "corners/sf.spice"
* Resistor/Capacitor
.include "r+c/res_low__cap_high.spice"
.include "r+c/res_low__cap_high__lin.spice"
* Special cells
.include "corners/sf/specialized_cells.spice"
.endl sflh

* Slow-Fast corner (sfll)
.lib sfll
.param mc_mm_switch=0
.param mc_pr_switch=0
* MOSFET
.include "corners/sf.spice"
* Resistor/Capacitor
.include "r+c/res_low__cap_low.spice"
.include "r+c/res_low__cap_low__lin.spice"
* Special cells
.include "corners/sf/specialized_cells.spice"
.endl sfll

* Fast-Fast low-low corner (ffll)
.lib ffll
.param mc_mm_switch=0
.param mc_pr_switch=0
* MOSFET
.include "corners/ff.spice"
* Resistor/Capacitor
.include "r+c/res_low__cap_low.spice"
.include "r+c/res_low__cap_low__lin.spice"
* Special cells
.include "corners/ff/specialized_cells.spice"
.endl ffll

* Fast-Fast high-high corner (ffhh)
.lib ffhh
.param mc_mm_switch=0
.param mc_pr_switch=0
* MOSFET
.include "corners/ff.spice"
* Resistor/Capacitor
.include "r+c/res_low__cap_low.spice"
.include "r+c/res_low__cap_low__lin.spice"
* Special cells
.include "corners/ff/specialized_cells.spice"
.endl ffhh

* Fast-Fast high-low corner (ffhl)
.lib ffhl
.param mc_mm_switch=0
.param mc_pr_switch=0
* MOSFET
.include "corners/ff.spice"
* Resistor/Capacitor
.include "r+c/res_high__cap_low.spice"
.include "r+c/res_high__cap_low__lin.spice"
* Special cells
.include "corners/ff/specialized_cells.spice"
.endl ffhl

* Fast-Fast low-high corner (fflh)
.lib fflh
.param mc_mm_switch=0
.param mc_pr_switch=0
* MOSFET
.include "corners/ff.spice"
* Resistor/Capacitor
.include "r+c/res_low__cap_high.spice"
.include "r+c/res_low__cap_high__lin.spice"
* Special cells
.include "corners/ff/specialized_cells.spice"
.endl ffhlh

* Slow-Slow corner (sshh)
.lib sshh
.param mc_mm_switch=0
.param mc_pr_switch=0
* MOSFET
.include "corners/ss.spice"
* Resistor/Capacitor
.include "r+c/res_high__cap_high.spice"
.include "r+c/res_high__cap_high__lin.spice"
* Special cells
.include "corners/ss/specialized_cells.spice"
.endl sshh

* Slow-Slow corner (ssll)
.lib ssll
.param mc_mm_switch=0
.param mc_pr_switch=0
* MOSFET
.include "corners/ss.spice"
* Resistor/Capacitor
.include "r+c/res_low__cap_low.spice"
.include "r+c/res_low__cap_low__lin.spice"
* Special cells
.include "corners/ss/specialized_cells.spice"
.endl ssll

* Slow-Slow corner (sshl)
.lib sshl
.param mc_mm_switch=0
.param mc_pr_switch=0
* MOSFET
.include "corners/ss.spice"
* Resistor/Capacitor
.include "r+c/res_high__cap_low.spice"
.include "r+c/res_high__cap_low__lin.spice"
* Special cells
.include "corners/ss/specialized_cells.spice"
.endl sshl

* Slow-Slow corner (sslh)
.lib sslh
.param mc_mm_switch=0
.param mc_pr_switch=0
* MOSFET
.include "corners/ss.spice"
* Resistor/Capacitor
.include "r+c/res_low__cap_high.spice"
.include "r+c/res_low__cap_high__lin.spice"
* Special cells
.include "corners/ss/specialized_cells.spice"
.endl sslh

* Fast-Slow corner (fsll)
.lib fsll
.param mc_mm_switch=0
.param mc_pr_switch=0
* MOSFET
.include "corners/fs.spice"
* Resistor/Capacitor
.include "r+c/res_low__cap_low.spice"
.include "r+c/res_low__cap_low__lin.spice"
* Special cells
.include "corners/fs/specialized_cells.spice"
.endl fsll

* Fast-Slow corner (fslh)
.lib fslh
.param mc_mm_switch=0
.param mc_pr_switch=0
* MOSFET
.include "corners/fs.spice"
* Resistor/Capacitor
.include "r+c/res_low__cap_high.spice"
.include "r+c/res_low__cap_high__lin.spice"
* Special cells
.include "corners/fs/specialized_cells.spice"
.endl fslh

* Fast-Slow corner (fshl)
.lib fshl
.param mc_mm_switch=0
.param mc_pr_switch=0
* MOSFET
.include "corners/fs.spice"
* Resistor/Capacitor
.include "r+c/res_high__cap_low.spice"
.include "r+c/res_high__cap_low__lin.spice"
* Special cells
.include "corners/fs/specialized_cells.spice"
.endl fshl

* Fast-Slow corner (fshh)
.lib fshh
.param mc_mm_switch=0
.param mc_pr_switch=0
* MOSFET
.include "corners/fs.spice"
* Resistor/Capacitor
.include "r+c/res_high__cap_high.spice"
.include "r+c/res_high__cap_high__lin.spice"
* Special cells
.include "corners/fs/specialized_cells.spice"
.endl fshh
